**************************************************
* Manufacturer:           Würth Elektronik
* Kinds:                  Auxiliary Gate Drive Transformer
* Matchcode:              WE-AGDT
* Library Type:           LTspice
* Version:                rev26a
* Created/modified by:    Ella
* Date and Time:          2026-04-20
* Team:                   eiSos EDA Service
* Contact:                libraries@we-online.com
**************************************************
* Copyright(C) 2026 Würth Elektronik eiSos GmbH & Co. KG
* All Rights Reserved.
**************************************************
* Disclaimer: While Würth Elektronik eiSos has made every reasonable effort to ensure the accuracy
* of the simulation models provided, Würth Elektronik eiSos does not guarantee the exemption of error on
* the simulation models, nor does Würth Elektronik eiSos guarantee that the simulation model is current.
* Würth Elektronik eiSos reserves the right to make any adjustments at any time without notice.
* Würth Elektronik eiSos expressly disclaims all implied warranties regarding this simulation model.
**************************************************
.subckt	750319836		1  3  8  6
.param RxLkg=1904.41ohm
.param Leakage=0.85uh
Rlkg	1	1a	{RxLkg}
L_Lkg	1	1a	{Leakage}	Rser=0.01mohm
Lpri1	1a	3	38.15uH	Rser=45mohm
Lsec1	8	6	96.306uH	Rser=125mohm
K Lpri1    Lsec1        1
.param Cprm1=12.77pf
.param Rdmp1=87378.85ohm
Cpri1	1	3	{Cprm1}	Rser=10mohm
Rdmp1	1	3	{Rdmp1}
Rg3	1	0	20meg
Rg7	3	0	20meg
Rg11	8	0	20meg
Rg19	6	0	20meg
.ends

.subckt	750319835		1  3  8  6
.param RxLkg=2033.1ohm
.param Leakage=0.755uh
Rlkg	1	1a	{RxLkg}
L_Lkg	1	1a	{Leakage}	Rser=0.01mohm
Lpri1	1a	3	38.245uH	Rser=60mohm
Lsec1	8	6	64.469uH	Rser=65mohm
K Lpri1    Lsec1        1
.param Cprm1=8.84pf
.param Rdmp1=105021.05ohm
Cpri1	1	3	{Cprm1}	Rser=10mohm
Rdmp1	1	3	{Rdmp1}
Rg3	1	0	20meg
Rg7	3	0	20meg
Rg11	8	0	20meg
Rg19	6	0	20meg
.ends

.subckt	750319834		1  3  8  6
.param RxLkg=2652.68ohm
.param Leakage=2.25uh
Rlkg	1	1a	{RxLkg}
L_Lkg	1	1a	{Leakage}	Rser=0.01mohm
Lpri1	1a	3	112.75uH	Rser=105mohm
Lsec1	8	6	134.965uH	Rser=100mohm
K Lpri1    Lsec1        1
.param Cprm1=15.64pf
.param Rdmp1=135581.62ohm
Cpri1	1	3	{Cprm1}	Rser=10mohm
Rdmp1	1	3	{Rdmp1}
Rg3	1	0	20meg
Rg7	3	0	20meg
Rg11	8	0	20meg
Rg19	6	0	20meg
.ends

.subckt	750319833		1  3  8  6
.param RxLkg=3775.85ohm
.param Leakage=2.2uh
Rlkg	1	1a	{RxLkg}
L_Lkg	1	1a	{Leakage}	Rser=0.01mohm
Lpri1	1a	3	112.8uH	Rser=105mohm
Lsec1	8	6	79.861uH	Rser=75mohm
K Lpri1    Lsec1        1
.param Cprm1=7.38pf
.param Rdmp1=197374.05ohm
Cpri1	1	3	{Cprm1}	Rser=10mohm
Rdmp1	1	3	{Rdmp1}
Rg3	1	0	20meg
Rg7	3	0	20meg
Rg11	8	0	20meg
Rg19	6	0	20meg
.ends

.subckt	750319832		1  3  8  6
.param RxLkg=3947.45ohm
.param Leakage=1.9uh
Rlkg	1	1a	{RxLkg}
L_Lkg	1	1a	{Leakage}	Rser=0.01mohm
Lpri1	1a	3	96.1uH	Rser=100mohm
Lsec1	8	6	29.157uH	Rser=23mohm
K Lpri1    Lsec1        1
.param Cprm1=5.91pf
.param Rdmp1=203605.23ohm
Cpri1	1	3	{Cprm1}	Rser=10mohm
Rdmp1	1	3	{Rdmp1}
Rg3	1	0	20meg
Rg7	3	0	20meg
Rg11	8	0	20meg
Rg19	6	0	20meg
.ends

.subckt	750319831		1  3  8  6
.param RxLkg=4266.15ohm
.param Leakage=1.9uh
Rlkg	1	1a	{RxLkg}
L_Lkg	1	1a	{Leakage}	Rser=0.01mohm
Lpri1	1a	3	96.1uH	Rser=100mohm
Lsec1	8	6	20.248uH	Rser=18mohm
K Lpri1    Lsec1        1
.param Cprm1=5.06pf
.param Rdmp1=220043.34ohm
Cpri1	1	3	{Cprm1}	Rser=10mohm
Rdmp1	1	3	{Rdmp1}
Rg3	1	0	20meg
Rg7	3	0	20meg
Rg11	8	0	20meg
Rg19	6	0	20meg
.ends

.subckt	750317893		1  3  2  4  8  5
.param RxLkg=875.14ohm
.param Leakage=0.328uh
Rlkg	1	1a	{RxLkg*2}
L_Lkg	1	1a	{Leakage*2}	Rser=0.01mohm
Rlkg2	2	2a	{RxLkg*2}
L_Lkg2	2	2a	{Leakage*2}	Rser=0.01mohm
Lpri1	1a	3	17.672uH	Rser=166mohm
Lpri2	2a	4	17.672uH	Rser=166mohm
Lsec1	8	5	72uH	Rser=395mohm
K Lpri1 Lpri2   Lsec1        1
.param Cprm1=9.755pf
.param Cprm2=9.755pf
.param Rdmp1=48026.1ohm
.param Rdmp2=48026.1ohm
Cpri1	1	3	{Cprm1}	Rser=10mohm
Cpri2	2	4	{Cprm2}	Rser=10mohm
Rdmp1	1	3	{Rdmp1}
Rdmp2	2	4	{Rdmp2}
Rg3	1	0	20meg
Rg4	2	0	20meg
Rg7	3	0	20meg
Rg8	4	0	20meg
Rg11	8	0	20meg
Rg19	5	0	20meg
.ends

.subckt	750317894		1  4  8  5  7  6
.param RxLkg=1097.35ohm
.param Leakage=0.255uh
Rlkg	1	1a	{RxLkg}
L_Lkg	1	1a	{Leakage}	Rser=0.01mohm
Lpri1	1a	4	17.745uH	Rser=85mohm
Lsec1	8	5	43.556uH	Rser=260mohm
Lsec2	7	6	3.556uH	Rser=85mohm
K Lpri1    Lsec1 Lsec2       1
.param Cprm1=7.5pf
.param Rdmp1=77459.69ohm
Cpri1	1	4	{Cprm1}	Rser=10mohm
Rdmp1	1	4	{Rdmp1}
Rg3	1	0	20meg
Rg7	4	0	20meg
Rg11	8	0	20meg
Rg12	7	0	20meg
Rg19	5	0	20meg
Rg20	6	0	20meg
.ends

.subckt	750318114		1  3  2  4  8  6
.param RxLkg=1249.42ohm
.param Leakage=0.285uh
Rlkg	1	1a	{RxLkg*2}
L_Lkg	1	1a	{Leakage*2}	Rser=0.01mohm
Rlkg2	2	2a	{RxLkg*2}
L_Lkg2	2	2a	{Leakage*2}	Rser=0.01mohm
Lpri1	1a	3	5.715uH	Rser=120mohm
Lpri2	2a	4	5.715uH	Rser=120mohm
Lsec1	8	6	24uH	Rser=285mohm
K Lpri1 Lpri2   Lsec1        1
.param Cprm1=10.84pf
.param Cprm2=10.84pf
.param Rdmp1=26303.65ohm
.param Rdmp2=26303.65ohm
Cpri1	1	3	{Cprm1}	Rser=10mohm
Cpri2	2	4	{Cprm2}	Rser=10mohm
Rdmp1	1	3	{Rdmp1}
Rdmp2	2	4	{Rdmp2}
Rg3	1	0	20meg
Rg4	2	0	20meg
Rg7	3	0	20meg
Rg8	4	0	20meg
Rg11	8	0	20meg
Rg19	6	0	20meg
.ends

.subckt	750318131		1  3  2  4  8  6  7  5
.param RxLkg=1517.91ohm
.param Leakage=0.27uh
Rlkg	1	1a	{RxLkg*2}
L_Lkg	1	1a	{Leakage*2}	Rser=0.01mohm
Rlkg2	2	2a	{RxLkg*2}
L_Lkg2	2	2a	{Leakage*2}	Rser=0.01mohm
Lpri1	1a	3	6.73uH	Rser=94mohm
Lpri2	2a	4	6.73uH	Rser=94mohm
Lsec1	8	6	16.938uH	Rser=205mohm
Lsec2	7	5	1.383uH	Rser=71mohm
K Lpri1 Lpri2   Lsec1 Lsec2       1
.param Cprm1=5.65pf
.param Cprm2=5.65pf
.param Rdmp1=39353.16ohm
.param Rdmp2=39353.16ohm
Cpri1	1	3	{Cprm1}	Rser=10mohm
Cpri2	2	4	{Cprm2}	Rser=10mohm
Rdmp1	1	3	{Rdmp1}
Rdmp2	2	4	{Rdmp2}
Rg3	1	0	20meg
Rg4	2	0	20meg
Rg7	3	0	20meg
Rg8	4	0	20meg
Rg11	8	0	20meg
Rg12	7	0	20meg
Rg19	6	0	20meg
Rg20	5	0	20meg
.ends

.subckt	750318207		1  4  8  5
.param RxLkg=1822.36ohm
.param Leakage=0.539uh
Rlkg	1	1a	{RxLkg}
L_Lkg	1	1a	{Leakage}	Rser=0.01mohm
Lpri1	1a	4	26.461uH	Rser=240mohm
Lsec1	8	5	38.88uH	Rser=353mohm
K Lpri1    Lsec1        1
.param Cprm1=8.1pf
.param Rdmp1=91287.02ohm
Cpri1	1	4	{Cprm1}	Rser=10mohm
Rdmp1	1	4	{Rdmp1}
Rg3	1	0	20meg
Rg7	4	0	20meg
Rg11	8	0	20meg
Rg19	5	0	20meg
.ends

.subckt	750318208		1  4  8  5  7  6
.param RxLkg=1748.22ohm
.param Leakage=0.325uh
Rlkg	1	1a	{RxLkg}
L_Lkg	1	1a	{Leakage}	Rser=0.01mohm
Lpri1	1a	4	26.675uH	Rser=155mohm
Lsec1	8	5	27uH	Rser=250mohm
Lsec2	7	6	2.204uH	Rser=85mohm
K Lpri1    Lsec1 Lsec2       1
.param Cprm1=3.2pf
.param Rdmp1=145236.83ohm
Cpri1	1	4	{Cprm1}	Rser=10mohm
Rdmp1	1	4	{Rdmp1}
Rg3	1	0	20meg
Rg7	4	0	20meg
Rg11	8	0	20meg
Rg12	7	0	20meg
Rg19	5	0	20meg
Rg20	6	0	20meg
.ends

.subckt	750318616		1  3  2  4  8  5
.param RxLkg=585.54ohm
.param Leakage=0.12uh
Rlkg	1	1a	{RxLkg}
L_Lkg	1	1a	{Leakage}	Rser=0.01mohm
Lpri1	1a	3	9.88uH	Rser=50mohm
Laux1	2	4	6.944uH	Rser=104mohm
Lsec1	8	5	27.778uH	Rser=260mohm
K Lpri1  Laux1  Lsec1        1
.param Cprm1=10.5pf
.param Rdmp1=48795.03ohm
Cpri1	1	3	{Cprm1}	Rser=10mohm
Rdmp1	1	3	{Rdmp1}
Rg3	1	0	20meg
Rg5	2	0	20meg
Rg7	3	0	20meg
Rg9	4	0	20meg
Rg11	8	0	20meg
Rg19	5	0	20meg
.ends

.subckt	750319077		2  1  4  3  5  6  7  8
.param RxLkg=568.63ohm
.param Leakage=0.39uh
Rlkg	2	2a	{RxLkg}
L_Lkg	2	2a	{Leakage}	Rser=0.01mohm
Lpri1	2a	1	41.61uH	Rser=195mohm
Laux1	4	3	10.5uH	Rser=132mohm
Lsec1	5	6	85.714uH	Rser=1300mohm
Lsec2	7	6	21.429uH	Rser=700mohm
Lsec3	6	8	21.429uH	Rser=700mohm
K Lpri1  Laux1  Lsec1 Lsec2 Lsec3      1
.param Cprm1=28pf
.param Rdmp1=61237.34ohm
Cpri1	2	1	{Cprm1}	Rser=10mohm
Rdmp1	2	1	{Rdmp1}
Rg3	2	0	20meg
Rg5	4	0	20meg
Rg7	1	0	20meg
Rg9	3	0	20meg
Rg11	5	0	20meg
Rg12	7	0	20meg
Rg19	6	0	20meg
Rg21	8	0	20meg
.ends

.subckt	750319177		1  3  8  6
.param RxLkg=1513.83ohm
.param Leakage=0.55uh
Rlkg	1	1a	{RxLkg}
L_Lkg	1	1a	{Leakage}	Rser=0.01mohm
Lpri1	1a	3	29.45uH	Rser=45mohm
Lsec1	8	6	83.333uH	Rser=115mohm
K Lpri1    Lsec1        1
.param Cprm1=11pf
.param Rdmp1=82572.36ohm
Cpri1	1	3	{Cprm1}	Rser=10mohm
Rdmp1	1	3	{Rdmp1}
Rg3	1	0	20meg
Rg7	3	0	20meg
Rg11	8	0	20meg
Rg19	6	0	20meg
.ends

.subckt	750319282		2  1  4  3  5  6  7  8
.param RxLkg=586.95ohm
.param Leakage=0.65uh
Rlkg	2	2a	{RxLkg}
L_Lkg	2	2a	{Leakage}	Rser=0.01mohm
Lpri1	2a	1	41.35uH	Rser=215mohm
Laux1	4	3	17.357uH	Rser=196mohm
Lsec1	5	6	262.5uH	Rser=2400mohm
Lsec2	6	8	17.357uH	Rser=660mohm
Lsec3	7	6	17.357uH	Rser=660mohm
K Lpri1  Laux1  Lsec1 Lsec2 Lsec3      1
.param Cprm1=73pf
.param Rdmp1=37925.76ohm
Cpri1	2	1	{Cprm1}	Rser=10mohm
Rdmp1	2	1	{Rdmp1}
Rg3	2	0	20meg
Rg5	4	0	20meg
Rg7	1	0	20meg
Rg9	3	0	20meg
Rg11	5	0	20meg
Rg13	7	0	20meg
Rg19	6	0	20meg
Rg20	8	0	20meg
.ends

.subckt	750319331		1  3  8  6
.param RxLkg=2970.44ohm
.param Leakage=1.5uh
Rlkg	1	1a	{RxLkg}
L_Lkg	1	1a	{Leakage}	Rser=0.01mohm
Lpri1	1a	3	73.5uH	Rser=85mohm
Lsec1	8	6	75uH	Rser=85mohm
K Lpri1    Lsec1        1
.param Cprm1=8.5pf
.param Rdmp1=148522.25ohm
Cpri1	1	3	{Cprm1}	Rser=10mohm
Rdmp1	1	3	{Rdmp1}
Rg3	1	0	20meg
Rg7	3	0	20meg
Rg11	8	0	20meg
Rg19	6	0	20meg
.ends

.subckt	750319496		1  3  8  6  7  5
.param RxLkg=1192.28ohm
.param Leakage=0.275uh
Rlkg	1	1a	{RxLkg}
L_Lkg	1	1a	{Leakage}	Rser=0.01mohm
Lpri1	1a	3	6.725uH	Rser=42mohm
Lsec1	8	6	28uH	Rser=370mohm
Lsec2	7	5	2.16uH	Rser=115mohm
K Lpri1    Lsec1 Lsec2       1
.param Cprm1=19pf
.param Rdmp1=30348.84ohm
Cpri1	1	3	{Cprm1}	Rser=10mohm
Rdmp1	1	3	{Rdmp1}
Rg3	1	0	20meg
Rg7	3	0	20meg
Rg11	8	0	20meg
Rg12	7	0	20meg
Rg19	6	0	20meg
Rg20	5	0	20meg
.ends

.subckt	750319497		1  3  8  6  7  5
.param RxLkg=1122.95ohm
.param Leakage=0.245uh
Rlkg	1	1a	{RxLkg}
L_Lkg	1	1a	{Leakage}	Rser=0.01mohm
Lpri1	1a	3	6.755uH	Rser=42mohm
Lsec1	8	6	24.975uH	Rser=350mohm
Lsec2	7	5	1.383uH	Rser=95mohm
K Lpri1    Lsec1 Lsec2       1
.param Cprm1=17pf
.param Rdmp1=32084.43ohm
Cpri1	1	3	{Cprm1}	Rser=10mohm
Rdmp1	1	3	{Rdmp1}
Rg3	1	0	20meg
Rg7	3	0	20meg
Rg11	8	0	20meg
Rg12	7	0	20meg
Rg19	6	0	20meg
Rg20	5	0	20meg
.ends

.subckt	750319565		1  3  8  6
.param RxLkg=1562.5ohm
.param Leakage=2.5uh
Rlkg	1	1a	{RxLkg}
L_Lkg	1	1a	{Leakage}	Rser=0.01mohm
Lpri1	1a	3	253.5uH	Rser=275mohm
Lsec1	8	6	1024uH	Rser=345mohm
K Lpri1    Lsec1        1
.param Cprm1=25pf
.param Rdmp1=160000.26ohm
Cpri1	1	3	{Cprm1}	Rser=10mohm
Rdmp1	1	3	{Rdmp1}
Rg3	1	0	20meg
Rg7	3	0	20meg
Rg11	8	0	20meg
Rg19	6	0	20meg
.ends

.subckt	750317493		2  5  8  7  9  10
.param RxLkg=206.07ohm
.param Leakage=0.204uh
Rlkg	2	2a	{RxLkg}
L_Lkg	2	2a	{Leakage}	Rser=0.01mohm
Lpri1	2a	5	1399.796uH	Rser=266mohm
Lsec1	8	7	1607.143uH	Rser=304mohm
Lsec2	9	10	1607.143uH	Rser=304mohm
K Lpri1    Lsec1 Lsec2       1
.param Cprm1=1.75pf
.param Rdmp1=1414215.58ohm
Cpri1	2	5	{Cprm1}	Rser=10mohm
Rdmp1	2	5	{Rdmp1}
Rg3	2	0	20meg
Rg7	5	0	20meg
Rg11	8	0	20meg
Rg12	9	0	20meg
Rg19	7	0	20meg
Rg20	10	0	20meg
.ends

.subckt	750318016		2  5  8  7  9  10
.param RxLkg=197.14ohm
.param Leakage=0.212uh
Rlkg	2	2a	{RxLkg}
L_Lkg	2	2a	{Leakage}	Rser=0.01mohm
Lpri1	2a	5	1399.788uH	Rser=290mohm
Lsec1	8	7	1592.889uH	Rser=321mohm
Lsec2	9	10	1592.889uH	Rser=310mohm
K Lpri1    Lsec1 Lsec2       1
.param Cprm1=2.065pf
.param Rdmp1=1301884.79ohm
Cpri1	2	5	{Cprm1}	Rser=10mohm
Rdmp1	2	5	{Rdmp1}
Rg3	2	0	20meg
Rg7	5	0	20meg
Rg11	8	0	20meg
Rg12	9	0	20meg
Rg19	7	0	20meg
Rg20	10	0	20meg
.ends

.subckt	750319374		2  5  8  7  9  10
.param RxLkg=3114.24ohm
.param Leakage=2.28uh
Rlkg	2	2a	{RxLkg}
L_Lkg	2	2a	{Leakage}	Rser=0.01mohm
Lpri1	2a	5	997.72uH	Rser=89.1mohm
Lsec1	8	7	340.278uH	Rser=54.3mohm
Lsec2	9	10	340.278uH	Rser=54.9mohm
K Lpri1    Lsec1 Lsec2       1
.param Cprm1=1.34pf
.param Rdmp1=1365895.37ohm
Cpri1	2	5	{Cprm1}	Rser=10mohm
Rdmp1	2	5	{Rdmp1}
Rg3	2	0	20meg
Rg7	5	0	20meg
Rg11	8	0	20meg
Rg12	9	0	20meg
Rg19	7	0	20meg
Rg20	10	0	20meg
.ends

.subckt	750319375		2  5  8  7  9  10
.param RxLkg=1533.43ohm
.param Leakage=1.75uh
Rlkg	2	2a	{RxLkg}
L_Lkg	2	2a	{Leakage}	Rser=0.01mohm
Lpri1	2a	5	1098.25uH	Rser=76mohm
Lsec1	8	7	704uH	Rser=77mohm
Lsec2	9	10	704uH	Rser=76mohm
K Lpri1    Lsec1 Lsec2       1
.param Cprm1=2.96pf
.param Rdmp1=963871.41ohm
Cpri1	2	5	{Cprm1}	Rser=10mohm
Rdmp1	2	5	{Rdmp1}
Rg3	2	0	20meg
Rg7	5	0	20meg
Rg11	8	0	20meg
Rg12	9	0	20meg
Rg19	7	0	20meg
Rg20	10	0	20meg
.ends

.subckt	750319376		2  5  8  7  9  10
.param RxLkg=1413.33ohm
.param Leakage=1.5uh
Rlkg	2	2a	{RxLkg}
L_Lkg	2	2a	{Leakage}	Rser=0.01mohm
Lpri1	2a	5	1098.5uH	Rser=66mohm
Lsec1	8	7	488.889uH	Rser=63mohm
Lsec2	9	10	488.889uH	Rser=66mohm
K Lpri1    Lsec1 Lsec2       1
.param Cprm1=2.56pf
.param Rdmp1=1036442.2ohm
Cpri1	2	5	{Cprm1}	Rser=10mohm
Rdmp1	2	5	{Rdmp1}
Rg3	2	0	20meg
Rg7	5	0	20meg
Rg11	8	0	20meg
Rg12	9	0	20meg
Rg19	7	0	20meg
Rg20	10	0	20meg
.ends

.subckt	750319377		2  5  8  7  9  10
.param RxLkg=1.17ohm
.param Leakage=0.001uh
Rlkg	2	2a	{RxLkg}
L_Lkg	2	2a	{Leakage}	Rser=0.01mohm
Lpri1	2a	5	674.999uH	Rser=57mohm
Lsec1	8	7	344.388uH	Rser=55mohm
Lsec2	9	10	344.388uH	Rser=55mohm
K Lpri1    Lsec1 Lsec2       1
.param Cprm1=2.71pf
.param Rdmp1=789108.38ohm
Cpri1	2	5	{Cprm1}	Rser=10mohm
Rdmp1	2	5	{Rdmp1}
Rg3	2	0	20meg
Rg7	5	0	20meg
Rg11	8	0	20meg
Rg12	9	0	20meg
Rg19	7	0	20meg
Rg20	10	0	20meg
.ends

.subckt	750319917		2  5  8  7  9  10
.param RxLkg=106.9ohm
.param Leakage=0.24uh
Rlkg	2	2a	{RxLkg}
L_Lkg	2	2a	{Leakage}	Rser=0.01mohm
Lpri1	2a	5	1549.76uH	Rser=340mohm
Lsec1	8	7	4555.102uH	Rser=561mohm
Lsec2	9	10	4555.102uH	Rser=549mohm
K Lpri1    Lsec1 Lsec2       1
.param Cprm1=8.13pf
.param Rdmp1=690383.52ohm
Cpri1	2	5	{Cprm1}	Rser=10mohm
Rdmp1	2	5	{Rdmp1}
Rg3	2	0	20meg
Rg7	5	0	20meg
Rg11	8	0	20meg
Rg12	9	0	20meg
Rg19	7	0	20meg
Rg20	10	0	20meg
.ends

.subckt	750320925		5  2  7  8  10  9
.param RxLkg=244.41ohm
.param Leakage=0.135uh
Rlkg	5	5a	{RxLkg}
L_Lkg	5	5a	{Leakage}	Rser=0.01mohm
Lpri1	5a	2	674.865uH	Rser=69mohm
Lsec1	7	8	344.388uH	Rser=62mohm
Lsec2	10	9	344.388uH	Rser=62mohm
K Lpri1    Lsec1 Lsec2       1
.param Cprm1=1.13pf
.param Rdmp1=1222032.26ohm
Cpri1	5	2	{Cprm1}	Rser=10mohm
Rdmp1	5	2	{Rdmp1}
Rg3	5	0	20meg
Rg7	2	0	20meg
Rg11	7	0	20meg
Rg12	10	0	20meg
Rg19	8	0	20meg
Rg20	9	0	20meg
.ends

.subckt	750320012		2  4  8  7  9  10
.param RxLkg=1121.85ohm
.param Leakage=0.66uh
Rlkg	2	2a	{RxLkg}
L_Lkg	2	2a	{Leakage}	Rser=0.01mohm
Lpri1	2a	4	103.34uH	Rser=88mohm
Lsec1	8	7	135.837uH	Rser=122mohm
Lsec2	9	10	135.837uH	Rser=122mohm
K Lpri1    Lsec1 Lsec2       1
.param Cprm1=8.32pf
.param Rdmp1=176776.87ohm
Cpri1	2	4	{Cprm1}	Rser=10mohm
Rdmp1	2	4	{Rdmp1}
Rg3	2	0	20meg
Rg7	4	0	20meg
Rg11	8	0	20meg
Rg12	9	0	20meg
Rg19	7	0	20meg
Rg20	10	0	20meg
.ends
