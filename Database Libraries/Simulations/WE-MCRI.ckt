**************************************************
* Manufacturer:           Würth Elektronik
* Kinds:                  SMT Molded Coupled Inductor
* Matchcode:              WE-MCRI
* Library Type:           LTspice
* Version:                rev26a
* Created/modified by:    Ella
* Date and Time:          2026-05-20
* Team:                   eiSos EDA Service
* Contact:                libraries@we-online.com
**************************************************
* Copyright(C) 2026 Würth Elektronik eiSos GmbH & Co. KG
* All Rights Reserved.
**************************************************
* Disclaimer: While Würth Elektronik eiSos has made every reasonable effort to ensure the accuracy
* of the simulation models provided, Würth Elektronik eiSos does not guarantee the exemption of error on
* the simulation models, nor does Würth Elektronik eiSos guarantee that the simulation model is current.
* Würth Elektronik eiSos reserves the right to make any adjustments at any time without notice.
* Würth Elektronik eiSos expressly disclaims all implied warranties regarding this simulation model.
**************************************************
.subckt  1090_7448990010_1u  1  2  3  4  PARAMS:
+  Cww=76p
+  Rp1=2131
+  Cp1=18.45p
+  Lp1=1.112u
+  Rp2=2113
+  Cp2=19.055p
+  Lp2=1.076u
+  RDC1=0.007
+  RDC2=0.007
+  K=0.9
C_C1 3 1 {Cww/2}
R_R50 3 1 5000g
C_C2 4 2 {Cww/2}
C_C5 4 3 {Cp1}
R_R1 4 N05454 {RDC1}
R_R2 4 3 {Rp1}
L_L1 N05454 3 {Lp1}
L_L2 N05750 1 {Lp2}
C_C6 2 1 {Cp2}
R_R3 2 1 {Rp2}
R_R4 2 N05750 {RDC2}
Kn_K1  L_L1  L_L2      {K}
.ends
******
.subckt  1090_7448990015_1.5u  1  2  3  4  PARAMS:
+  Cww=79p
+  Rp1=2700
+  Cp1=19.49p
+  Lp1=1.454u
+  Rp2=2741
+  Cp2=19.35p
+  Lp2=1.554u
+  RDC1=0.016
+  RDC2=0.016
+  K=0.921592824046137
C_C1 3 1 {Cww/2}
R_R50 3 1 5000g
C_C2 4 2 {Cww/2}
C_C5 4 3 {Cp1}
R_R1 4 N05454 {RDC1}
R_R2 4 3 {Rp1}
L_L1 N05454 3 {Lp1}
L_L2 N05750 1 {Lp2}
C_C6 2 1 {Cp2}
R_R3 2 1 {Rp2}
R_R4 2 N05750 {RDC2}
Kn_K1  L_L1  L_L2      {K}
.ends
******
.subckt  1090_7448990022_2.2u  1  2  3  4  PARAMS:
+  Cww=90p
+  Rp1=4880
+  Cp1=26.707p
+  Lp1=2.555u
+  Rp2=4518
+  Cp2=26.989p
+  Lp2=2.528u
+  RDC1=0.022
+  RDC2=0.022
+  K=0.945082968940727
C_C1 3 1 {Cww/2}
R_R50 3 1 5000g
C_C2 4 2 {Cww/2}
C_C5 4 3 {Cp1}
R_R1 4 N05454 {RDC1}
R_R2 4 3 {Rp1}
L_L1 N05454 3 {Lp1}
L_L2 N05750 1 {Lp2}
C_C6 2 1 {Cp2}
R_R3 2 1 {Rp2}
R_R4 2 N05750 {RDC2}
Kn_K1  L_L1  L_L2      {K}
.ends
******
.subckt  1090_7448990033_3.3u  1  2  3  4  PARAMS:
+  Cww=99p
+  Rp1=6700
+  Cp1=20.581p
+  Lp1=3.316u
+  Rp2=6635
+  Cp2=20.7p
+  Lp2=3.297u
+  RDC1=0.028
+  RDC2=0.028
+  K=0.9613752775282
C_C1 3 1 {Cww/2}
R_R50 3 1 5000g
C_C2 4 2 {Cww/2}
C_C5 4 3 {Cp1}
R_R1 4 N05454 {RDC1}
R_R2 4 3 {Rp1}
L_L1 N05454 3 {Lp1}
L_L2 N05750 1 {Lp2}
C_C6 2 1 {Cp2}
R_R3 2 1 {Rp2}
R_R4 2 N05750 {RDC2}
Kn_K1  L_L1  L_L2      {K}
.ends
******
.subckt  1090_7448990047_4.7u  1  2  3  4  PARAMS:
+  Cww=98p
+  Rp1=4913
+  Cp1=22.582p
+  Lp1=4.574u
+  Rp2=5004
+  Cp2=22.507p
+  Lp2=4.559u
+  RDC1=0.035
+  RDC2=0.035
+  K=0.972275243403929
C_C1 3 1 {Cww/2}
R_R50 3 1 5000g
C_C2 4 2 {Cww/2}
C_C5 4 3 {Cp1}
R_R1 4 N05454 {RDC1}
R_R2 4 3 {Rp1}
L_L1 N05454 3 {Lp1}
L_L2 N05750 1 {Lp2}
C_C6 2 1 {Cp2}
R_R3 2 1 {Rp2}
R_R4 2 N05750 {RDC2}
Kn_K1  L_L1  L_L2      {K}
.ends
******
.subckt  1090_7448990068_6.8u  1  2  3  4  PARAMS:
+  Cww=131p
+  Rp1=6400
+  Cp1=23.196p
+  Lp1=6.671u
+  Rp2=6631
+  Cp2=23.057p
+  Lp2=6.712u
+  RDC1=0.048
+  RDC2=0.048
+  K=0.980696031338127
C_C1 3 1 {Cww/2}
R_R50 3 1 5000g
C_C2 4 2 {Cww/2}
C_C5 4 3 {Cp1}
R_R1 4 N05454 {RDC1}
R_R2 4 3 {Rp1}
L_L1 N05454 3 {Lp1}
L_L2 N05750 1 {Lp2}
C_C6 2 1 {Cp2}
R_R3 2 1 {Rp2}
R_R4 2 N05750 {RDC2}
Kn_K1  L_L1  L_L2      {K}
.ends
******
.subckt  1090_7448990082_8.2u  1  2  3  4  PARAMS:
+  Cww=162p
+  Rp1=4896
+  Cp1=25.504p
+  Lp1=8.998u
+  Rp2=4972
+  Cp2=25.148p
+  Lp2=9.125u
+  RDC1=0.059
+  RDC2=0.059
+  K=0.983398785199426
C_C1 3 1 {Cww/2}
R_R50 3 1 5000g
C_C2 4 2 {Cww/2}
C_C5 4 3 {Cp1}
R_R1 4 N05454 {RDC1}
R_R2 4 3 {Rp1}
L_L1 N05454 3 {Lp1}
L_L2 N05750 1 {Lp2}
C_C6 2 1 {Cp2}
R_R3 2 1 {Rp2}
R_R4 2 N05750 {RDC2}
Kn_K1  L_L1  L_L2      {K}
.ends
******
.subckt  1090_7448990100_10u  1  2  3  4  PARAMS:
+  Cww=178p
+  Rp1=7321
+  Cp1=28.172p
+  Lp1=10.072u
+  Rp2=7421
+  Cp2=28.127p
+  Lp2=10.088u
+  RDC1=0.064
+  RDC2=0.064
+  K=0.986154146165801
C_C1 3 1 {Cww/2}
R_R50 3 1 5000g
C_C2 4 2 {Cww/2}
C_C5 4 3 {Cp1}
R_R1 4 N05454 {RDC1}
R_R2 4 3 {Rp1}
L_L1 N05454 3 {Lp1}
L_L2 N05750 1 {Lp2}
C_C6 2 1 {Cp2}
R_R3 2 1 {Rp2}
R_R4 2 N05750 {RDC2}
Kn_K1  L_L1  L_L2      {K}
.ends
******
.subckt  1090_7448990150_15u  1  2  3  4  PARAMS:
+  Cww=199p
+  Rp1=8298
+  Cp1=26.456p
+  Lp1=15.755u
+  Rp2=8175
+  Cp2=26.386p
+  Lp2=15.757u
+  RDC1=0.075
+  RDC2=0.075
+  K=0.990252493054171
C_C1 3 1 {Cww/2}
R_R50 3 1 5000g
C_C2 4 2 {Cww/2}
C_C5 4 3 {Cp1}
R_R1 4 N05454 {RDC1}
R_R2 4 3 {Rp1}
L_L1 N05454 3 {Lp1}
L_L2 N05750 1 {Lp2}
C_C6 2 1 {Cp2}
R_R3 2 1 {Rp2}
R_R4 2 N05750 {RDC2}
Kn_K1  L_L1  L_L2      {K}
.ends
******
.subckt  1090_7448990220_22u  1  2  3  4  PARAMS:
+  Cww=226p
+  Rp1=9865
+  Cp1=24.449p
+  Lp1=20.839u
+  Rp2=10350
+  Cp2=24.482p
+  Lp2=20.811u
+  RDC1=0.099
+  RDC2=0.099
+  K=0.99304398877208
C_C1 3 1 {Cww/2}
R_R50 3 1 5000g
C_C2 4 2 {Cww/2}
C_C5 4 3 {Cp1}
R_R1 4 N05454 {RDC1}
R_R2 4 3 {Rp1}
L_L1 N05454 3 {Lp1}
L_L2 N05750 1 {Lp2}
C_C6 2 1 {Cp2}
R_R3 2 1 {Rp2}
R_R4 2 N05750 {RDC2}
Kn_K1  L_L1  L_L2      {K}
.ends
******
.subckt  1090_7448990330_33u  1  2  3  4  PARAMS:
+  Cww=345p
+  Rp1=11110
+  Cp1=29.2p
+  Lp1=32.34u
+  Rp2=11322
+  Cp2=29.225p
+  Lp2=32.429u
+  RDC1=0.129
+  RDC2=0.129
+  K=0.994530496812898
C_C1 3 1 {Cww/2}
R_R50 3 1 5000g
C_C2 4 2 {Cww/2}
C_C5 4 3 {Cp1}
R_R1 4 N05454 {RDC1}
R_R2 4 3 {Rp1}
L_L1 N05454 3 {Lp1}
L_L2 N05750 1 {Lp2}
C_C6 2 1 {Cp2}
R_R3 2 1 {Rp2}
R_R4 2 N05750 {RDC2}
Kn_K1  L_L1  L_L2      {K}
.ends
******
.subckt  1090_7448990470_47u  1  2  3  4  PARAMS:
+  Cww=363p
+  Rp1=26460
+  Cp1=26.452p
+  Lp1=44.153u
+  Rp2=28240
+  Cp2=29.49p
+  Lp2=44.089u
+  RDC1=0.222
+  RDC2=0.222
+  K=0.996162850909386
C_C1 3 1 {Cww/2}
R_R50 3 1 5000g
C_C2 4 2 {Cww/2}
C_C5 4 3 {Cp1}
R_R1 4 N05454 {RDC1}
R_R2 4 3 {Rp1}
L_L1 N05454 3 {Lp1}
L_L2 N05750 1 {Lp2}
C_C6 2 1 {Cp2}
R_R3 2 1 {Rp2}
R_R4 2 N05750 {RDC2}
Kn_K1  L_L1  L_L2      {K}
.ends
******
**************************************************
* Manufacturer:           Würth Elektronik
* Kinds:                  SMT Molded Coupled Inductor
* Matchcode:              WE-MCRI
* Library Type:           spice
* Version:                rev
* Created/modified by:    Ella
* Date and Time:          1/13/2026
* Team:                   eiSos EDA Service
* Contact:                libraries@we-online.com
**************************************************
* Copyright(C) 2026 Würth Elektronik eiSos GmbH & Co. KG
* All Rights Reserved.
**************************************************
* Disclaimer: While Würth Elektronik eiSos has made every reasonable effort to ensure the accuracy
* of the simulation models provided, Würth Elektronik eiSos does not guarantee the exemption of error on
* the simulation models, nor does Würth Elektronik eiSos guarantee that the simulation model is current.
* Würth Elektronik eiSos reserves the right to make any adjustments at any time without notice.
* Würth Elektronik eiSos expressly disclaims all implied warranties regarding this simulation model.
**************************************************
.subckt 1090HL_7448992010_1u 1  2  3  4  PARAMS:
+  Cww=40.9p
+  Rp1=1240
+  Cp1=22.835p
+  Lp1=0.966429u
+  Rp2=1240
+  Cp2=22.835p
+  Lp2=0.966429u
+  RDC1=0.0047
+  RDC2=0.0000047
+  K=0.72389288284221
C_C1 3 1 {Cww/2}
R_R50 3 1 5000g
C_C2 4 2 {Cww/2}
C_C5 4 3 {Cp1}
R_R1 4 N05454 {RDC1}
R_R2 4 3 {Rp1}
L_L1 N05454 3 {Lp1}
L_L2 N05750 1 {Lp2}
C_C6 2 1 {Cp2}
R_R3 2 1 {Rp2}
R_R4 2 N05750 {RDC2}
Kn_K1  L_L1  L_L2  {K}
.ends
*******
.subckt 1090HL_7448992015_1.5u 1  2  3  4  PARAMS:
+  Cww=34.7p
+  Rp1=2048
+  Cp1=20.463p
+  Lp1=1.486u
+  Rp2=2048
+  Cp2=20.463p
+  Lp2=1.486u
+  RDC1=0.0079
+  RDC2=0.0000079
+  K=0.76779034823481
C_C1 3 1 {Cww/2}
R_R50 3 1 5000g
C_C2 4 2 {Cww/2}
C_C5 4 3 {Cp1}
R_R1 4 N05454 {RDC1}
R_R2 4 3 {Rp1}
L_L1 N05454 3 {Lp1}
L_L2 N05750 1 {Lp2}
C_C6 2 1 {Cp2}
R_R3 2 1 {Rp2}
R_R4 2 N05750 {RDC2}
Kn_K1  L_L1  L_L2  {K}
.ends
*******
.subckt 1090HL_7448992022_2.2u 1  2  3  4  PARAMS:
+  Cww=28.1p
+  Rp1=3002
+  Cp1=24.181p
+  Lp1=2.032u
+  Rp2=3002
+  Cp2=24.181p
+  Lp2=2.032u
+  RDC1=0.0095
+  RDC2=0.0000095
+  K=0.677245463124586
C_C1 3 1 {Cww/2}
R_R50 3 1 5000g
C_C2 4 2 {Cww/2}
C_C5 4 3 {Cp1}
R_R1 4 N05454 {RDC1}
R_R2 4 3 {Rp1}
L_L1 N05454 3 {Lp1}
L_L2 N05750 1 {Lp2}
C_C6 2 1 {Cp2}
R_R3 2 1 {Rp2}
R_R4 2 N05750 {RDC2}
Kn_K1  L_L1  L_L2  {K}
.ends
*******
.subckt 1090HL_7448992033_3.3u 1  2  3  4  PARAMS:
+  Cww=34.3p
+  Rp1=3532
+  Cp1=23.24p
+  Lp1=3.156u
+  Rp2=3532
+  Cp2=23.24p
+  Lp2=3.156u
+  RDC1=0.023
+  RDC2=0.000023
+  K=0.83415675415014
C_C1 3 1 {Cww/2}
R_R50 3 1 5000g
C_C2 4 2 {Cww/2}
C_C5 4 3 {Cp1}
R_R1 4 N05454 {RDC1}
R_R2 4 3 {Rp1}
L_L1 N05454 3 {Lp1}
L_L2 N05750 1 {Lp2}
C_C6 2 1 {Cp2}
R_R3 2 1 {Rp2}
R_R4 2 N05750 {RDC2}
Kn_K1  L_L1  L_L2  {K}
.ends
*******
.subckt 1090HL_7448992047_4.7u 1  2  3  4  PARAMS:
+  Cww=33.3p
+  Rp1=4189
+  Cp1=22.724p
+  Lp1=4.478u
+  Rp2=4189
+  Cp2=22.724p
+  Lp2=4.478u
+  RDC1=0.036
+  RDC2=0.000036
+  K=0.842432090265056
C_C1 3 1 {Cww/2}
R_R50 3 1 5000g
C_C2 4 2 {Cww/2}
C_C5 4 3 {Cp1}
R_R1 4 N05454 {RDC1}
R_R2 4 3 {Rp1}
L_L1 N05454 3 {Lp1}
L_L2 N05750 1 {Lp2}
C_C6 2 1 {Cp2}
R_R3 2 1 {Rp2}
R_R4 2 N05750 {RDC2}
Kn_K1  L_L1  L_L2  {K}
.ends
*******
.subckt 1090HL_7448992068_6.8u 1  2  3  4  PARAMS:
+  Cww=36.4p
+  Rp1=4149
+  Cp1=28.017p
+  Lp1=6.781u
+  Rp2=4149
+  Cp2=28.017p
+  Lp2=6.781u
+  RDC1=0.046
+  RDC2=0.000046
+  K=0.821927050348734
C_C1 3 1 {Cww/2}
R_R50 3 1 5000g
C_C2 4 2 {Cww/2}
C_C5 4 3 {Cp1}
R_R1 4 N05454 {RDC1}
R_R2 4 3 {Rp1}
L_L1 N05454 3 {Lp1}
L_L2 N05750 1 {Lp2}
C_C6 2 1 {Cp2}
R_R3 2 1 {Rp2}
R_R4 2 N05750 {RDC2}
Kn_K1  L_L1  L_L2  {K}
.ends
*******
.subckt 1090HL_7448992082_8.2u 1  2  3  4  PARAMS:
+  Cww=36.3p
+  Rp1=5003
+  Cp1=29.007p
+  Lp1=8.949u
+  Rp2=5003
+  Cp2=29.007p
+  Lp2=8.949u
+  RDC1=0.057
+  RDC2=0.000057
+  K=0.720763057742411
C_C1 3 1 {Cww/2}
R_R50 3 1 5000g
C_C2 4 2 {Cww/2}
C_C5 4 3 {Cp1}
R_R1 4 N05454 {RDC1}
R_R2 4 3 {Rp1}
L_L1 N05454 3 {Lp1}
L_L2 N05750 1 {Lp2}
C_C6 2 1 {Cp2}
R_R3 2 1 {Rp2}
R_R4 2 N05750 {RDC2}
Kn_K1  L_L1  L_L2  {K}
.ends
*******
.subckt 1090HL_7448992100_10u 1  2  3  4  PARAMS:
+  Cww=37.5p
+  Rp1=7463
+  Cp1=28.811p
+  Lp1=10.532u
+  Rp2=7463
+  Cp2=28.811p
+  Lp2=10.532u
+  RDC1=0.06
+  RDC2=0.00006
+  K=0.775380773371635
C_C1 3 1 {Cww/2}
R_R50 3 1 5000g
C_C2 4 2 {Cww/2}
C_C5 4 3 {Cp1}
R_R1 4 N05454 {RDC1}
R_R2 4 3 {Rp1}
L_L1 N05454 3 {Lp1}
L_L2 N05750 1 {Lp2}
C_C6 2 1 {Cp2}
R_R3 2 1 {Rp2}
R_R4 2 N05750 {RDC2}
Kn_K1  L_L1  L_L2  {K}
.ends
*******
.subckt 1090HL_7448992150_15u 1  2  3  4  PARAMS:
+  Cww=34.1p
+  Rp1=7617
+  Cp1=23.512p
+  Lp1=15.085u
+  Rp2=7617
+  Cp2=23.512p
+  Lp2=15.085u
+  RDC1=0.076
+  RDC2=0.000076
+  K=0.784545790958505
C_C1 3 1 {Cww/2}
R_R50 3 1 5000g
C_C2 4 2 {Cww/2}
C_C5 4 3 {Cp1}
R_R1 4 N05454 {RDC1}
R_R2 4 3 {Rp1}
L_L1 N05454 3 {Lp1}
L_L2 N05750 1 {Lp2}
C_C6 2 1 {Cp2}
R_R3 2 1 {Rp2}
R_R4 2 N05750 {RDC2}
Kn_K1  L_L1  L_L2  {K}
.ends
*******
.subckt 1090HL_7448992220_22u 1  2  3  4  PARAMS:
+  Cww=35.8p
+  Rp1=14036
+  Cp1=22.785p
+  Lp1=21.27u
+  Rp2=14036
+  Cp2=22.785p
+  Lp2=21.27u
+  RDC1=0.093
+  RDC2=0.000093
+  K=0.734341316911022
C_C1 3 1 {Cww/2}
R_R50 3 1 5000g
C_C2 4 2 {Cww/2}
C_C5 4 3 {Cp1}
R_R1 4 N05454 {RDC1}
R_R2 4 3 {Rp1}
L_L1 N05454 3 {Lp1}
L_L2 N05750 1 {Lp2}
C_C6 2 1 {Cp2}
R_R3 2 1 {Rp2}
R_R4 2 N05750 {RDC2}
Kn_K1  L_L1  L_L2  {K}
.ends
*******
.subckt 1090HL_7448992330_33u 1  2  3  4  PARAMS:
+  Cww=39p
+  Rp1=17152
+  Cp1=26.046p
+  Lp1=34.738u
+  Rp2=17152
+  Cp2=26.046p
+  Lp2=34.738u
+  RDC1=0.128
+  RDC2=0.000128
+  K=0.730514824334691
C_C1 3 1 {Cww/2}
R_R50 3 1 5000g
C_C2 4 2 {Cww/2}
C_C5 4 3 {Cp1}
R_R1 4 N05454 {RDC1}
R_R2 4 3 {Rp1}
L_L1 N05454 3 {Lp1}
L_L2 N05750 1 {Lp2}
C_C6 2 1 {Cp2}
R_R3 2 1 {Rp2}
R_R4 2 N05750 {RDC2}
Kn_K1  L_L1  L_L2  {K}
.ends
*******
.subckt 1090HL_7448992470_47u 1  2  3  4  PARAMS:
+  Cww=38p
+  Rp1=11639
+  Cp1=29.858p
+  Lp1=48.397u
+  Rp2=11639
+  Cp2=29.858p
+  Lp2=48.397u
+  RDC1=0.206
+  RDC2=0.000206
+  K=0.573123697801615
C_C1 3 1 {Cww/2}
R_R50 3 1 5000g
C_C2 4 2 {Cww/2}
C_C5 4 3 {Cp1}
R_R1 4 N05454 {RDC1}
R_R2 4 3 {Rp1}
L_L1 N05454 3 {Lp1}
L_L2 N05750 1 {Lp2}
C_C6 2 1 {Cp2}
R_R3 2 1 {Rp2}
R_R4 2 N05750 {RDC2}
Kn_K1  L_L1  L_L2  {K}
.ends
*******
